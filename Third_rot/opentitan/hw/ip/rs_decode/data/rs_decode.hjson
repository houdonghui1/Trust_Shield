{
  name:               "rs_decode",
  human_name:         "rs_decode Accelerator",
  one_line_desc:      "rs_decode encryption engine ",
  one_paragraph_desc: '''
  [Advanced Encryption Standard (rs_decode)][rs_decode] 
  '''
  // Unique comportable IP identifier defined under KNOWN_CIP_IDS in the regtool.
  cip_id:             "35",
  design_spec:        "../doc",
  dv_doc:             "../doc/dv",
  hw_checklist:       "../doc/checklist",
  sw_checklist:       "/sw/device/lib/dif/dif_rs_decode",
  version:            "1.0.0",
  life_stage:         "L1",
  design_stage:       "D2S",
  verification_stage: "V2S",
  dif_stage:          "S2",
  clocking: [
    {clock: "clk_i", reset: "rst_ni"},
  ]
    bus_interfaces: [
    { protocol: "tlul", direction: "device" }
  ],

param_list: [
    { name:    "NumRegs_encoded_data_in",
      type:    "int",
      default: "50",
      desc:    "Number registers for input data",
      local:   "true"
    },
    { name:    "NumRegs_error_pos_out",
      type:    "int",
      default: "50",
      desc:    "Number registers for output data",
      local:   "true"
    },

],

//定义寄存器

regwidth: "32",
registers: [
##############################################################################

//控制寄存器
  { name: "CTRL_SIGNALS",
    desc: '''
      Control 
    '''
    swaccess: "rw",
    hwaccess: "hrw",
    hwqe:     "true",
    fields: [
      { bits: "0",
        name: "decode_en",
        resval: "0x0",
        hwaccess: "hrw",
        desc:  '''
          enable core to decode
        '''
      }
      { bits: "1",
        name: "clrn",
        resval: "0x1",
        hwaccess: "hrw",
        desc:  '''
          la di jiu hui qing ling
        '''
      }      
            ]
  },

// 状态寄存器
  { name: "STATE_SIGNALS",
    desc: '''
      The rs_decode states 
    '''
    swaccess: "ro",
    hwaccess: "hrw",
    fields: [
      { bits: "0",
        name: "output_valid_bit",
        resval: "0x0",
        hwaccess: "hrw",
        desc:  '''
          valid signal of decoded_data
        '''
      }
      { bits: "1",
        name: "ready_bit",
        resval: "0x0",
        hwaccess: "hrw",
        desc:  '''
          ready signal of rs_decode,can read outdata and start new decode count.
        '''
      }
      { bits: "2",
        name: "with_error_bit",
        resval: "0x0",
        hwaccess: "hrw",
        desc:  '''
          with error signal of rs_decode,means the encoded_data has wrong to data_in.
        '''
      }
            ]
    },

# input encoded_data
    { multireg: {
      name: "Encoded_Data_In",
      resval: "0",
      desc: '''
        data input
      '''
      count: "NumRegs_encoded_data_in",
      cname: "encoded_data_in",
      swaccess: "rw",
      hwaccess: "hrw",
      hwqe:     "true",
      fields: [
        { bits: "31:0", name: "encoded_data_in", desc: "encoded_data_in" }
      ],
      }
    },
# output error_pos
    { multireg: {
      name: "Error_Pos_OUT",
      resval: "0",
      desc: '''
        result output
      '''
      count: "NumRegs_error_pos_out",
      cname: "error_pos_out",
      swaccess: "ro",
      hwaccess: "hrw",
      fields: [
        { bits: "31:0", name: "error_pos_out", desc: "error_pos_out" }
      ],
      }
    },
  ],
}
